** Profile: "SCHEMATIC1-QLoad"  [ G:\Telecom\01\ex1\ex1-pspicefiles\schematic1\qload.sim ]

** Creating circuit file "QLoad.cir"
** WARNING: THIS AUTOMATICALLY GENERATED FILE MAY BE OVERWRITTEN BY SUBSEQUENT SIMULATIONS

*Libraries:
* Profile Libraries :
* Local Libraries :
* From [PSPICE NETLIST] section of C:\OrCAD\OrCAD_10.3\tools\PSpice\PSpice.ini file:
.lib "nom.lib"

*Analysis directives:
.AC DEC 1000 100000 10000000
.PROBE V(alias(*)) I(alias(*)) W(alias(*)) D(alias(*)) NOISE(alias(*))
.INC "..\SCHEMATIC1.net"

.END
